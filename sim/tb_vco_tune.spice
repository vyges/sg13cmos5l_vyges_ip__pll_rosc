* tb_vco_tune -- ring VCO oscillation and tuning, driven from the SCHEMATIC hierarchy.
* Number to beat is the 2026-07-17 feasibility run on the flat netlist
* (prototype/rosc-pll/rosc_vco.spice): 155.7 MHz at vctrl = 0.6 V, rail-to-rail swing.
.lib $PDK_ROOT/ihp-sg13cmos5l/libs.tech/ngspice/models/cornerMOSlv.lib mos_tt
.include $PDK_ROOT/ihp-sg13cmos5l/libs.ref/sg13cmos5l_stdcell/spice/sg13cmos5l_stdcell.spice
.include ../sim/netlist/rosc_vco.spice

Vdd   vdd   0 1.2
Vss   vss   0 0
Vctrl vctrl 0 0.6
.ic v(n1)=0

.control
  tran 2p 60n uic
  meas tran vmax MAX v(n1) from=10n to=60n
  meas tran vmin MIN v(n1) from=10n to=60n
  meas tran per4 TRIG v(n1) VAL=0.6 RISE=2 TARG v(n1) VAL=0.6 RISE=6
  let freq = 4/per4
  print vmax vmin per4 freq
.endc
.end
